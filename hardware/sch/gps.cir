* 项目 D:\work\pads\gps\sch\gps.cir
* 生成 Mentor Graphics 线路表，版本 1.0.0
* Inifile   :
* Options   :

* 跳过元器件 C1 可能因为未找到 Sim.Analog.Prefix 属性。
* 跳过元器件 C2 可能因为未找到 Sim.Analog.Prefix 属性。
* 跳过元器件 C3 可能因为未找到 Sim.Analog.Prefix 属性。
* 跳过元器件 C4 可能因为未找到 Sim.Analog.Prefix 属性。
* 跳过元器件 C5 可能因为未找到 Sim.Analog.Prefix 属性。
* 跳过元器件 C6 可能因为未找到 Sim.Analog.Prefix 属性。
* 跳过元器件 C7 可能因为未找到 Sim.Analog.Prefix 属性。
* 跳过元器件 C8 可能因为未找到 Sim.Analog.Prefix 属性。

.END
